[IBIS Ver]   4.2
[File Name]  LED_ON.ibs
[File Rev]   3.0
[Date]   September 15, 2022
[Source]   Altera Corporation
[Notes]   - The models are designated as "Final" and have been correlated against physical device operation.
   - This IBIS model is checked using IBISCHK v5.0.4
   There are no known errors and warnings reported.
   - There are no known limitations for this IBIS model release.
   - Contact point: Altera Corporation, http://www.altera.com/corporate/contact/con-index.html
   - This file is generated using Quartus II Version 21.1.1 Build 850 06/23/2022 SJ Lite Edition
   - Unused IOs which have been assigned as tri-stated inputs or as outputs driving any signal in Quartus II
   arerepresented by the NC.
   - Only general purpose IBIS models are supported.
   Revision History
   - v1.0
   - Initial release of MAX 10 IBIS models. Models are based on pre-layout and early engineering info.
   - v2.0
   - Models are based on post-layout, may be missing certain features.
   - v3.0
   - Models have undergone final correlation against physical device operation.
[Disclaimer] Data is for modeling purposes only and is not guaranteed.
[Copyright]  Copyright (C) 2022  Intel Corporation. All rights reserved.
[Component]  10M50DAF484C7G_LED_ON
[Manufacturer] Altera Corporation
[Package]
| RLC values are for 484 FBGA package
| variable  typ   min   max
R_pkg   528m   154m   874m
L_pkg   4.73nH   1.76nH   8.14nH
C_pkg   1.01pF   0.54pF   1.67pF
[Pin] signal_name   model_name   R_pin   L_pin   C_pin
A1   GND   GND
A10   LED[2]   25_cio_r50   618.8m   5.890nH   1.083pF
A11   LED[8]   25_cio_r50   572.3m   5.833nH   1.012pF
A12   SW[4]   25_cin_p   548.0m   5.374nH   0.985pF
A13   SW[6]   25_cin_p   565.0m   4.694nH   0.976pF
A14   SW[7]   25_cin_p   539.8m   5.464nH   0.955pF
A16   segment2[7]   25_cio_r50_p   551.5m   4.756nH   1.106pF
A17   segment2[4]   25_cio_r50_p   622.8m   5.389nH   1.286pF
A18   segment2[5]   25_cio_r50_p   646.5m   5.203nH   1.362pF
A19   segment3[7]   25_cio_r50_p   797.4m   6.594nH   1.419pF
A20   segment3[1]   25_cio_r50_p   806.9m   7.451nH   1.498pF
A21   segment3[3]   25_rio_r50_p   852.2m   7.511nH   1.592pF
A22   GND   GND
A8   LED[0]   25_cio_r50   739.8m   7.540nH   1.314pF
A9   LED[1]   25_cio_r50   635.8m   6.193nH   1.167pF
AA1   VGA_R[0]   25_cio_r50   831.5m   8.088nH   1.631pF
AA18  GND   GND
AA2   RESET2   25_cio_r50   848.5m   7.293nH   1.571pF
AA4   GND   GND
AB1   GND   GND
AB22  GND   GND
AB8   buzzer   25_cio_r50   649.1m   6.831nH   1.219pF
B10   LED[3]   25_cio_r50   432.0m   3.866nH   0.928pF
B11   LED[9]   25_cio_r50   432.2m   4.170nH   0.927pF
B12   SW[5]   25_cin_p   428.1m   3.777nH   0.874pF
B13   GND   GND
B14   SW[8]   25_cin_p   531.5m   4.798nH   0.935pF
B16   segment2[3]   25_cio_r50_p   548.2m   4.460nH   1.125pF
B17   segment2[6]   25_cio_r50_p   583.7m   4.729nH   1.194pF
B18   GND   GND
B19   segment3[2]   25_cio_r50_p   750.6m   6.930nH   1.380pF
B20   segment3[0]   25_rio_r50_p   784.2m   7.629nH   1.484pF
B21   segment3[4]   25_rio_r50_p   810.9m   7.496nH   1.501pF
B22   segment3[6]   25_rio_r50_p   874.6m   7.174nH   1.590pF
B6   GND   GND
B8   boutton   25_cin_p   653.9m   5.581nH   1.235pF
B9   GND   GND
C10   SW[0]   25_cin_p   360.7m   3.168nH   0.905pF
C11   SW[1]   25_cin_p   356.1m   3.552nH   0.891pF
C12   SW[3]   25_cin_p   372.1m   3.451nH   0.787pF
C13   LED[5]   25_cio_r50   376.7m   3.306nH   0.800pF
C14   segment[0]   25_cio_r50_p   374.1m   3.688nH   0.772pF
C15   segment[2]   25_cio_r50_p   355.1m   3.646nH   0.863pF
C16   segment[3]   25_cio_r50_p   414.4m   3.789nH   0.966pF
C17   segment[6]   25_cio_r50_p   556.7m   4.473nH   0.983pF
C18   segment2[0]   25_cio_r50_p   528.4m   4.394nH   1.094pF
C19   segment4[3]   25_cio_r50_p   763.6m   6.298nH   1.380pF
C20   segment4[4]   25_rio_r50_p   749.1m   7.394nH   1.433pF
C22   segment3[5]   25_rio_r50_p   870.5m   8.142nH   1.672pF
D11   GND   GND
D12   SW[2]   25_cin_p   352.0m   3.084nH   0.728pF
D13   LED[4]   25_cio_r50   314.2m   2.794nH   0.627pF
D14   LED[7]   25_cio_r50   281.2m   2.837nH   0.717pF
D15   segment[7]   25_cio_r50_p   274.0m   2.723nH   0.721pF
D16   GND   GND
D17   segment[5]   25_cio_r50_p   565.9m   4.962nH   0.996pF
D18   segment2[1]   25_rio_r50_p   514.2m   4.734nH   1.044pF
D19   segment4[5]   25_rio_r50_p   708.9m   6.563nH   1.329pF
D20   GND   GND
D22   segment4[7]   25_rio_r50_p   873.7m   7.558nH   1.558pF
D4   GND   GND
E14   LED[6]   25_cio_r50   236.6m   2.129nH   0.596pF
E15   segment[1]   25_cio_r50_p   324.9m   2.789nH   0.681pF
E16   segment[4]   25_cio_r50_p   339.2m   3.035nH   0.711pF
E17   segment4[6]   25_rio_r50_p   483.8m   4.732nH   1.030pF
E18   segment2[2]   25_rio_r50_p   498.5m   4.115nH   1.034pF
E19   segment5[2]   25_rio_r50_p   565.4m   5.750nH   1.221pF
E2   GND   GND
E20   segment5[1]   25_rio_r50_p   632.0m   6.551nH   1.226pF
E21   segment4[2]   25_rio_r50_p   778.5m   6.938nH   1.410pF
E22   segment4[1]   25_rio_r50_p   802.9m   7.537nH   1.491pF
E3   ~ALTERA_ADC2IN8~   25_rin_p   528.3m   4.512nH   1.106pF
E4   ~ALTERA_ADC2IN1~   25_rin_p   501.4m   4.583nH   1.043pF
E7   GND   GND
F10   GND   GND
F11   VCCIO8   POWER
F12   VCCIO7   POWER
F13   GND   GND
F14   VCCIO7   POWER
F15   SW[9]   25_cin_p   264.6m   2.631nH   0.845pF
F17   segment5[7]   25_rio_r50_p   466.8m   4.718nH   1.000pF
F18   segment5[0]   25_rio_r50_p   511.9m   5.442nH   1.043pF
F19   segment5[5]   25_rio_r50_p   607.3m   5.799nH   1.111pF
F20   segment5[6]   25_rio_r50_p   650.1m   5.945nH   1.357pF
F21   segment4[0]   25_rio_r50_p   680.2m   6.239nH   1.405pF
F3   ~ALTERA_ADC2IN4~   25_rin_p   601.0m   6.005nH   1.141pF
F4   ~ALTERA_ADC1IN2~   25_rin_p   395.7m   3.705nH   0.989pF
F5   ~ALTERA_ADC1IN1~   25_rin_p   371.5m   3.496nH   0.920pF
F9   VCCIO8   POWER
G10   VCCIO8   POWER
G11   VCCIO8   POWER
G12   VCCIO7   POWER
G13   VCCIO7   POWER
G14   VCCIO7   POWER
G15   GND   GND
G16   VCCD_PLL2   POWER
G18   GND   GND
G21   GND   GND
G3   ~ALTERA_ADC2IN6~   25_rin_p   550.2m   5.626nH   1.011pF
G4   ~ALTERA_ADC2IN3~   25_rin_p   600.8m   5.324nH   1.116pF
G6   GND   GND
G7   VCCD_PLL3   POWER
G8   GND   GND
H15   VCCA2   POWER
H16   VCCIO6   POWER
H19   segment5[4]   25_rio_r50_p   261.8m   2.683nH   0.704pF
H3   ~ALTERA_ADC1IN6~   25_rin_p   382.9m   3.765nH   0.826pF
H4   ~ALTERA_ADC2IN5~   25_rin_p   544.8m   5.923nH   1.058pF
H7   VCCA_ADC   POWER
H8   VCCA3   POWER
J16   GND   GND
J17   VCCIO6   POWER
J18   segment5[3]   25_rio_r50_p   189.6m   2.001nH   0.545pF
J19   GND   GND
J2   GND   GND
J20   segment6[0]   25_rio_r50_p   423.1m   3.410nH   0.853pF
J3   ~ALTERA_ADC2IN2~   25_rin_p   360.5m   3.183nH   0.768pF
J4   ~ALTERA_ADC1IN5~   25_rin_p   361.0m   3.377nH   0.729pF
J6   GND   GND
J7   VCCINT   POWER
J8   ~ALTERA_ADC1IN3~   25_rin_p   154.6m   1.783nH   0.587pF
J9   ~ALTERA_ADC1IN4~   25_rin_p   188.6m   1.982nH   0.667pF
K10   GND   GND
K11   VCC   POWER
K12   GND   GND
K13   VCC   POWER
K16   VCCIO6   POWER
K17   VCCIO6   POWER
K20   segment6[1]   25_rio_r50_p   392.4m   3.688nH   0.802pF
K3   GND   GND
K4   ~ALTERA_ADC2IN7~   25_rin_p   322.1m   2.995nH   0.746pF
K5   ~ALTERA_ADC1IN7~   25_rin_p   189.7m   1.953nH   0.540pF
K6   ~ALTERA_ADC1IN8~   25_rin_p   181.2m   1.756nH   0.542pF
K7   VCCIO1A   POWER
L10   VCC   POWER
L11   VCC   POWER
L12   VCC   POWER
L13   GND   GND
L16   VCCIO6   POWER
L17   GND   GND
L18   segment6[2]   25_rio_r50_p   290.6m   2.908nH   0.757pF
L19   segment6[7]   25_rio_r50_p   459.9m   3.942nH   0.878pF
L21   GND   GND
L5   GND   GND
L6   VCCIO1A   POWER
L7   VCCIO1B   POWER
M10   GND   GND
M11   VCC   POWER
M12   VCC   POWER
M13   VCC   POWER
M16   GND   GND
M17   VCCIO6   POWER
M19   GND   GND
M20   segment6[4]   25_rio_r50_p   432.9m   4.020nH   0.848pF
M6   VCCIO1B   POWER
M7   GND   GND
N1   VGA_VS   25_rio_r50   562.3m   5.772nH   1.046pF
N10   VCC   POWER
N11   GND   GND
N12   VCC   POWER
N13   GND   GND
N16   VCCIO5   POWER
N17   VCCIO6   POWER
N18   segment6[3]   25_rio_r50_p   322.0m   3.439nH   0.764pF
N19   segment6[5]   25_rio_r50_p   329.7m   3.736nH   0.832pF
N2   VGA_B[3]   25_rio_r50   491.2m   4.983nH   0.903pF
N20   segment6[6]   25_rio_r50_p   469.3m   4.833nH   0.955pF
N3   VGA_HS   25_rio_r50   442.6m   4.334nH   0.802pF
N6   VCCIO2   POWER
N7   VCCIO2   POWER
P1   VGA_B[0]   25_rio_r50   548.9m   4.871nH   1.019pF
P11   clk   25_cin_p   176.5m   1.812nH   0.651pF
P16   VCCIO5   POWER
P17   GND   GND
P2   GND   GND
P4   VGA_B[2]   25_rio_r50   435.8m   4.115nH   0.958pF
P6   GND   GND
P7   VCCIO2   POWER
R1   VGA_G[3]   25_rio_r50   564.3m   5.023nH   1.113pF
R16   VCCIO5   POWER
R17   VCCIO5   POWER
R19   GND   GND
R2   VGA_G[2]   25_rio_r50   477.4m   5.188nH   0.897pF
R21   GND   GND
R6   VCCIO2   POWER
R8   VCCA1   POWER
T1   VGA_B[1]   25_rio_r50   575.3m   5.438nH   1.235pF
T10   VCCIO3   POWER
T11   VCCIO3   POWER
T12   VCCIO4   POWER
T13   VCCIO4   POWER
T14   GND   GND
T15   VCCA4   POWER
T16   GND   GND
T17   VCCIO5   POWER
T2   VGA_G[1]   25_rio_r50   560.7m   4.572nH   1.186pF
T4   GND   GND
T7   VCCD_PLL1   POWER
T8   GND   GND
T9   VCCIO3   POWER
U10   GND   GND
U11   VCCIO4   POWER
U12   VCCIO4   POWER
U13   GND   GND
U14   VCCIO4   POWER
U16   VCCD_PLL4   POWER
U8   VCCIO3   POWER
U9   VCCIO3   POWER
V1   VGA_R[1]   25_rio_r50   718.1m   6.793nH   1.308pF
V10   SER1   25_cio_r50   197.8m   1.886nH   0.561pF
V19   GND   GND
V2   GND   GND
V6   GND   GND
V7   RESET1   25_cio_r50   267.4m   2.521nH   0.710pF
V8   SRCLK1   25_cio_r50_p   263.6m   2.592nH   0.697pF
V9   SCLK1   25_cio_r50   221.7m   2.219nH   0.611pF
W1   VGA_G[0]   25_rio_r50   689.1m   5.514nH   1.359pF
W21   GND   GND
Y1   VGA_R[3]   25_cio_r50   863.3m   7.327nH   1.574pF
Y12   GND   GND
Y15   GND   GND
Y2   VGA_R[2]   25_cio_r50   818.0m   7.853nH   1.582pF
Y3   SRCLK2   25_cio_r50_p   711.4m   6.132nH   1.491pF
Y4   SCLK2   25_cio_r50   695.1m   6.058nH   1.464pF
Y5   SER2   25_cio_r50   536.2m   4.445nH   1.117pF
Y9   GND   GND
| Models and submodels in the file (6): 25_cin_p (Input), 25_cio_r50 (I/O), 25_cio_r50_p (I/O), 25_rin_p (Input), 25_rio_r50 (I/O), 25_rio_r50_p (I/O)
